/* nCDF.il

Author          Guilherme Trindade
Group           INESC-ID - Analog and Mixed-Signal Circuits (CAM)
Language        SKILL
Revision No.    1.0
Date Created    Mar 19, 2020
Modified
By:

************************
LIBRARY = "UMC130"
CELL    = "nCDF"
************************

*/

let( (cellId cdfId libName cellName)
  libName = "radiationLib"
  cellName = "N_ELT"
  when(cellId = ddGetObj(libName cellName)
    ;; if the cell CDF already exists, delete it
    when( cdfId = cdfGetBaseCellCDF(cellId)
      cdfDeleteCDF(cdfId)
    )
    ;; create the base cell CDF
    cdfId = cdfCreateBaseCellCDF(cellId)
    ;; create the parameters
    cdfCreateParam( cdfId
      ?name           "model"
      ?prompt         "Model name"
      ?defValue       "n_elt"
      ?type           "string"
      ?display        "nil"
      ?parseAsCEL     "yes"
    )
    cdfCreateParam( cdfId
      ?name     "l"
      ?prompt   "Length"
      ?units   "lengthMetric"
      ?defValue "0.2u"
      ?type     "string"
      ?storeDefault "yes"
      ?display  "t"
      ?editable "t"
      ?callback "calcWmethod()"
      ?parseAsNumber  "yes"
      ?parseAsCEL     "yes"
    )
    cdfCreateParam( cdfId
      ?name     "w"
      ?prompt   "Width"
      ?units   "lengthMetric"
      ?defValue "4.5u"
      ?type     "string"
      ?storeDefault "yes"
      ?display  "t"
      ?editable "t"
      ?callback "calcWmethod()"
      ?parseAsNumber  "yes"
      ?parseAsCEL     "yes"
    )
    cdfCreateParam( cdfId
      ?name     "d"
      ?prompt   "d"
      ?storeDefault "yes"
      ?units   "lengthMetric"
      ?defValue "0.7u"
      ?type     "string"
      ?display  "t"
      ?editable "nil"
      ?parseAsNumber  "yes"
      ?parseAsCEL     "yes"
    )
    cdfCreateParam( cdfId
      ?name     "h"
      ?prompt   "h"
      ?storeDefault "yes"
      ?units   "lengthMetric"
      ?defValue "0.15u"
      ?type     "string"
      ?display  "t"
      ?editable "nil"
      ?parseAsNumber  "yes"
      ?parseAsCEL     "yes"
    )
    cdfCreateParam( cdfId
      ?name     "dl"
      ?prompt   "dl"
      ?storeDefault "yes"
      ?units   "lengthMetric"
      ?defValue "0.085u"
      ?type     "string"
      ?display  "t"
      ?editable "nil"
      ?parseAsNumber  "yes"
      ?parseAsCEL     "yes"
    )
    cdfCreateParam( cdfId
      ?name     "sl"
      ?prompt   "sl"
      ?storeDefault "yes"
      ?units   "lengthMetric"
      ?defValue "0.36u"
      ?type     "string"
      ?display  "t"
      ?editable "nil"
      ?parseAsNumber  "yes"
      ?parseAsCEL     "yes"
    )
    ;; Simulator Information
    cdfId->simInfo = list( nil )
    cdfId->simInfo->auCdl = '( nil
      netlistProcedure  ansCdlSubcktCallExtended ;ansCdlCompPrim
      instParameters    (l w d dl)
      termOrder         (D G S B)
      propMapping       nil
      namePrefix        "M"
      ;componentName     N
      modelName         N_12_HSL130E
    )

    cdfId->simInfo->spectre = '( nil
      termMapping       (nil D \:d G \:g S \:s B \:b)
      instParameters    (w l m)
      otherParameters   (model)
      termOrder         (D G S B)
      ;propMapping       (nil m simM w effW nf fingers mf simM)
    )

    ;;; Properties
    cdfId->formInitProc            = ""
    cdfId->doneProc                = ""
    cdfId->buttonFieldWidth        = 340
    cdfId->fieldHeight             = 35
    cdfId->fieldWidth              = 350
    cdfId->promptWidth             = 175
    cdfId->paramLabelSet           = "-model l w"
    cdfId->opPointLabelSet         = "id vgs vds vth vdsat"
    cdfId->modelLabelSet           = "vtho vsat"

    cdfSaveCDF(cdfId)
  )
)
